.subckt inverter IN OUT VDD VSS

XM2 OUT IN VDD VDD sky130_fd_pr__pfet_01v8 l=0.15 w=1.26 as=0.378 ad=0.378 ps=3.12 pd=3.12

XM1 OUT IN VSS VSS sky130_fd_pr__nfet_01v8 l=0.15 w=0.42 as=0.126 ad=0.126 ps=1.44 pd=1.44

.ends inverter
