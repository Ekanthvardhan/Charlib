.subckt inverter a vdd vss z

xm01 z a vdd vdd sky130_fd_pr__pfet_01v8
+ l=0.15 w=1.26
+ as=0.378 ad=0.378
+ ps=3.12 pd=3.12

xm02 z a vss vss sky130_fd_pr__nfet_01v8
+ l=0.15 w=0.42
+ as=0.126 ad=0.126
+ ps=1.44 pd=1.44

c3 a vss 0.385f
c2 z vss 0.576f

.ends inverter
